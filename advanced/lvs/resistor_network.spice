* resistor_network.spice
* Schematic netlist for a tiny resistive divider:
*
*   VIN --[ R1=1k ]-- VOUT --[ R2=2k ]-- VSS
*
* This is the "intended" netlist (what the designer drew in the schematic).

R1 VIN VOUT 1000
R2 VOUT VSS 2000

.end
