* resistor_network_extracted.spice
* Layout-extracted netlist for the same divider:
*
*   VIN --[ R1=1k ]-- VOUT --[ R2=2k ]-- VSS
*
* This is what an extraction tool would produce from the GDS layout.
* The instance names are different on purpose (Rx_extracted vs R1/R2),
* which is normal — LVS should still recognize the two netlists as
* equivalent because the *devices*, *connections*, and *values* match.

Rx_extracted_1 VIN VOUT 1000
Rx_extracted_2 VOUT VSS 2000

.end
